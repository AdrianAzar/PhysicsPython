** Profile: "SCHEMATIC1-FullBridge"  [ c:\users\user\documents\BridgeRectifier\BridgeRectifier-PSpiceFiles\SCHEMATIC1\FullBridge.sim ]

** Creating circuit file "FullBridge.cir"
** WARNING: THIS AUTOMATICALLY GENERATED FILE MAY BE OVERWRITTEN BY SUBSEQUENT SIMULATIONS

*Libraries:
* Profile Libraries :
* Local Libraries :
* From [PSPICE NETLIST] section of C:\cds_spb_home\cdssetup\OrCAD_PSpiceTIPSpice_Install\23.1.0\PSpice.ini file:
.lib "C:\Users\User\Documents\tools\pspice\Library\nom.lib"
.lib "nom_pspti.lib"
.lib "nom.lib"

*Analysis directives:
.TRAN  0 5ms 0 0.001u
.OPTIONS ADVCONV
.OPTIONS FILEMODELSEARCH
.PROBE64 V(alias(*)) I(alias(*)) W(alias(*)) D(alias(*)) NOISE(alias(*))
.INC "..\SCHEMATIC1.net"

.END
